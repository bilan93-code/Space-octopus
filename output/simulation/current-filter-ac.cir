* Circuit JSON to SPICE Netlist
RR501 N1 N2 47
CC501 N2 0 1N
VINPUT N1 0 DC 0 AC 1
.options reltol=1e-8 abstol=1e-13 vntol=1e-9
.ac dec 40 33862.75384933943 338627538.4933943
.save v(N2)
.end
